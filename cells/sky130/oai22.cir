* OAI22 compound gate: y = !((a OR b) AND (c OR d))
* sky130 name: o22a.  Pull-down: two parallel pairs in series.
* Pull-up (complement): two series pairs in parallel.
.subckt oai22 a b c d y vdd
MN1 n1 a 0 0 nfet_01v8 W=1u L=0.15u
MN2 n1 b 0 0 nfet_01v8 W=1u L=0.15u
MN3 n2 c n1 0 nfet_01v8 W=1u L=0.15u
MN4 y d n2 0 nfet_01v8 W=1u L=0.15u
MP1 x1 a vdd vdd pfet_01v8 W=3u L=0.15u
MP2 y b x1 vdd pfet_01v8 W=3u L=0.15u
MP3 x2 c vdd vdd pfet_01v8 W=3u L=0.15u
MP4 y d x2 vdd pfet_01v8 W=3u L=0.15u
.ends
