* NOR2: y = !(a | b)
* pull-up: series pfets; pull-down: parallel nfets
.subckt nor2 a b y vdd
MP1 x1 a vdd vdd pfet_01v8 W=3u L=0.15u
MP2 y b x1 vdd pfet_01v8 W=3u L=0.15u
MN1 y a 0 0 nfet_01v8 W=1u L=0.15u
MN2 y b 0 0 nfet_01v8 W=1u L=0.15u
.ends
