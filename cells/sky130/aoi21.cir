* AOI21 compound gate: y = !((a AND b) OR c)
* sky130 name: a21o.  Pull-down: (a series b) in parallel with c.
* Pull-up (complement): (a parallel b) in series with c.
.subckt aoi21 a b c y vdd
MN1 n1 a 0 0 nfet_01v8 W=1u L=0.15u
MN2 y b n1 0 nfet_01v8 W=1u L=0.15u
MN3 y c 0 0 nfet_01v8 W=1u L=0.15u
MP1 x a vdd vdd pfet_01v8 W=3u L=0.15u
MP2 x b vdd vdd pfet_01v8 W=3u L=0.15u
MP3 y c x vdd pfet_01v8 W=3u L=0.15u
.ends
