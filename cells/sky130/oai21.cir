* OAI21 compound gate: y = !((a OR b) AND c)
* sky130 name: o21a.  Pull-down: (a parallel b) in series with c.
* Pull-up (complement): (a series b) in parallel with c.
.subckt oai21 a b c y vdd
MN1 n1 a 0 0 nfet_01v8 W=1u L=0.15u
MN2 n1 b 0 0 nfet_01v8 W=1u L=0.15u
MN3 y c n1 0 nfet_01v8 W=1u L=0.15u
MP1 x a vdd vdd pfet_01v8 W=3u L=0.15u
MP2 y b x vdd pfet_01v8 W=3u L=0.15u
MP3 y c vdd vdd pfet_01v8 W=3u L=0.15u
.ends
