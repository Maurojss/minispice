* NAND2: y = !(a & b)
* pull-up: parallel pfets; pull-down: series nfets
.subckt nand2 a b y vdd
MP1 y a vdd vdd pfet_01v8 W=3u L=0.15u
MP2 y b vdd vdd pfet_01v8 W=3u L=0.15u
MN1 n1 a 0 0 nfet_01v8 W=1u L=0.15u
MN2 y b n1 0 nfet_01v8 W=1u L=0.15u
.ends
