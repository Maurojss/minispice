Half-wave diode rectifier
V1 in 0 SIN(0 5 1k)
D1 in out DMOD
R1 out 0 1k
.model DMOD D(IS=1e-14 N=1)
.tran 10u 3m
.end
