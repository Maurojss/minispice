RC low-pass: step response, tau = R*C = 1 ms
V1 in 0 PULSE(0 1 0 1n 1n 100m 200m)
R1 in out 1k
C1 out 0 1u
.tran 10u 5m
.end
