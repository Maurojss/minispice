* Leakage currents: diode reverse saturation + off-state MOSFET subthreshold
*
* The diode is reverse-biased (cathode at 1.8 V, anode pulled to 0 V through
* the 1 meg resistor), so its current saturates at -IS = -1 pA: I(D1).
* The NMOS gate sits at 0 V (VTO = 0.5), so the only drain current is the
* didactic subthreshold tail (NSUB default 1.5 -> ~89 mV/decade at 27 C):
* it appears on I(VDD).
*
* NOTE: .options gmin=1e-15 keeps the numeric floor below the leakage.
.options gmin=1e-15

VDD d 0 dc 1.8
VR ck 0 dc 1.8
D1 cn ck DMOD
Rl cn 0 1meg
MN d g 0 0 NMOS W=1u L=1u
VG g 0 dc 0

.model DMOD D(IS=1e-12 N=1.0)
.model NMOS NMOS(VTO=0.5 KP=120u)
.op
.end
